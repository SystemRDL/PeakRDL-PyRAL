addrmap structural {
    default sw=rw;
    default hw=r;

    reg my_reg {
        field {} a[8] = 0x23;
        field {} b = 0;
        field {} c[31:31] = 1;
    };

    my_reg r0 @0x000;
    my_reg r1[2][3][4] @0x10 += 8;


    reg subreg {
        field {} x[7:4] = 1;
    };
    regfile subrf {
        subreg r1 @ 0x0;
        subreg r2[4] @ 0x10 += 4;
        regfile {
            subreg r1 @ 0x0;
            subreg r2[2] @ 0x4 += 4;
            subreg r3 @ 0xc;
        } sub[2] @ 0x20 += 0x10;
    };
    subrf sub1 @ 0x1000;
    subrf sub2[8] @ 0x2000 += 0x80;

    reg {
        field {} a[7:0];
        field {} b[23:16];
        field {} c[30:30];
        field {} d[31:31];
    } r2 @ 0x3000;

    signal {} my_signal;

    mem {
        mementries = 64;
        memwidth = 32;
    } external my_mem @ 0x4000;
};
