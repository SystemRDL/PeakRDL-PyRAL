addrmap name_collisions {
    reg {
        field {} access_size;
    } size;
};
