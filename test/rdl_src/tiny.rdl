addrmap tiny {
    reg {
        field {} f0;
    } r0;
};
